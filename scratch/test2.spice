* LED Test Circuit 2 - Two LEDs in parallel from 3.3V
* LED1 branch: V1 -> R1 -> D1 -> GND
* LED2 branch: V1 -> R2 -> D2 -> GND
V1 1 0 DC 3.3V              ; 3.3V supply
R1 1 2 470                  ; 470 Ohm current-limiting resistor for LED1
D1 2 0 MyLED                ; LED1 from node 2 to ground
R2 1 3 470                  ; 470 Ohm current-limiting resistor for LED2
D2 3 0 MyLED                ; LED2 from node 3 to ground

.model MyLED D(Is=1e-14 Rs=10 Bv=5 Ibv=1e-3) ; Simple Diode Model
.dc V1 0 3.3 0.1            ; Sweep voltage from 0 to 3.3V in 0.1V steps
.print dc i(V1) i(D1) i(D2) ; Track total and per-LED current
.end
